* Unified command-current supervisor - same components as schematic
V1 VIN 0 12
RF1 VIN FUSED .05
XS0 FUSED V12 SPST MODE=0
XU7 V12 0 V5 REG7805
C5 V12 0 100u
C1 V12 0 10u
C2 V12 0 100n
C3 V5 0 10u
C4 V5 0 100n
XS1 V12 LOAD_PLUS SPST MODE=1
RCOIL LOAD_PLUS COIL_MID {Rcoil}
L1 COIL_MID DRAIN {Lcoil}
D1 DRAIN LOAD_PLUS D5408_APPROX
MQ1 DRAIN GATE SHUNT IRLZ44N_APPROX
RS SHUNT 0 .22
XS4 0 V5 C SPDT MODE=4
XS5 C V5 DRIVE SPDT MODE=5
R1A DRIVE GATE 220
R1B DRIVE GATE 220
R2 GATE 0 100k
XU1 AMP FB SHUNT 0 0 UF UF V12 LM358_DUAL
R3 FB AMP 150k
R4 FB 0 10k
C8 V12 0 100n
R5 AMP S2_N 1k
XS2 S2_N TEST I_FILT SPDT MODE=2
C6 I_FILT 0 1u
XS3 V5 TEST_IN SPST MODE=3
RT3 TEST_IN TEST_R 1k
RT4 TEST_R TEST 33
RT1 TEST TEST_LOW 10k
RT2 TEST_LOW 0 33
XRV1 V5 VLOW 0 POT10K K=0.17
XRV2 V5 VHIGH 0 POT10K K=0.422
XRV3 V5 VPRESENT 0 POT10K K=0.042
XU2 LOW HIGH V12 VHIGH I_FILT I_FILT VLOW VPRESENT I_FILT VMID DELAY_IN 0 D PRESENT LM339_QUAD
R9 V5 LOW 10k
R10 V5 HIGH 10k
R11 V5 PRESENT 10k
R12 V5 D 10k
C9 V12 0 100n
R6 C DELAY_RC 100k
C7 DELAY_RC 0 1u
R7 DELAY_RC DELAY_IN 10k
R8 DELAY_IN D 470k
R13 V5 VMID 10k
R14 VMID 0 10k
XU3 C D QUAL QUAL LOW FU 0 FO QUAL HIGH FS OFF_ARM PRESENT V5 HC08
XU5 C D C_OR_D LOW HIGH LOW_OR_HIGH 0 F_UO FU FO FAULT F_UO FS V5 HC32
XU6 C_OR_D OFF_ARM LOW_OR_HIGH CURRENT_OK 0 NC6 0 NC8 0 NC10 0 NC12 0 V5 HC04
XU4 QUAL CURRENT_OK NORMAL 0 0 NC_U4_6 0 NC_U4_8 0 0 NC_U4_11 0 0 V5 HC08
C10 V5 0 100n
C11 V5 0 100n
C12 V5 0 100n
C13 V5 0 100n
R15 NORMAL D3_A 1k
D3 D3_A 0 LED_GREEN
R16 FU D4_A 1k
D4 D4_A 0 LED_YELLOW
R17 FO D5_A 1k
D5 D5_A 0 LED_RED
R18 FS D6_A 1k
D6 D6_A 0 LED_RED
R19 FAULT BASE 1k
R20 BASE 0 100k
Q2 BUZ_LO BASE 0 Q3904
XBZ1 V5 BUZ_LO BUZZER5
D2 BUZ_LO V5 D4148
.include UnifiedSupervisor20261028.lib
.param Rcoil=30 Lcoil=100m
.tran 0 6.4 0 500u
.options plotwinsize=0 reltol=.003 method=gear
.save V(V12) V(V5) V(C) V(D) V(GATE) V(DRAIN) V(SHUNT) V(AMP) V(I_FILT) V(DELAY_RC) V(LOW) V(HIGH) V(PRESENT) V(NORMAL) V(FU) V(FO) V(FS) V(FAULT) I(L1) I(RS) I(R19) I(R15) I(R16) I(R17) I(R18) V(BUZ_LO)
.meas TRAN Coil_Normal AVG I(L1) FROM=1 TO=1.4
.meas TRAN Sense_Normal AVG V(I_FILT) FROM=1 TO=1.4
.meas TRAN V5_Min MIN V(V5)
.meas TRAN Delay_Rise TRIG V(C) VAL=2.5 RISE=1 TARG V(D) VAL=2.5 RISE=1
.meas TRAN Open_Under AVG V(FU) FROM=1.8 TO=2.1
.meas TRAN LowTest_Under AVG V(FU) FROM=3.7 TO=3.85
.meas TRAN HighTest_Over AVG V(FO) FROM=4.05 TO=4.2
.meas TRAN HighTest_Coil AVG I(L1) FROM=4.05 TO=4.2
.meas TRAN Stuck_Fault AVG V(FS) FROM=5.2 TO=5.6
.meas TRAN Idle_Fault MAX V(FAULT) FROM=.1 TO=.4
.meas TRAN Normal_Fault MAX V(FAULT) FROM=.7 TO=1.4
.meas TRAN Turnoff_Fault MAX V(FAULT) FROM=2.5 TO=2.9
.end
